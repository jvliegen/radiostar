* Simple audio amp for 32 ohm speaker

.include spice_models/NPN_2N3904.mod
.include spice_models/PNP_2N3906.mod

Vsignal vin 0 SIN(4.5 3 440)

V1 vcc 0 DC 9

C1 vin 1 10µ

R1 vcc 1   220k
R2 1   0   47k

Rc vcc 2 47k
Re 3 0 1k
Ce 3 0 100µ

* Qn C B E NPN_model
Q1 2 1 3 2N3904

C2 2 stage1_out 10µ

R3 vcc stage1_out 10k
R4 stage1_out 0 10k

* Qn C B E NPN_model
Q2 vcc stage1_out 4 2N3904
R5 4 5 47

R6 5 6 47
* Qn C B E NPN_model
Q3 6 stage1_out 0 2N3906

C3 5 stage2_out 100µ

* .tran tstep tstop <tstart <tmax>> <uic>
.tran 1µ 20m
* .tran 0.01µ 1m

********************************************************************************
* Control part
********************************************************************************
.control
run
plot v(vcc) v(vin) v(stage1_out)  v(stage2_out)
.endc

.end

* dx (peak-to-peak) = 0.000116071
