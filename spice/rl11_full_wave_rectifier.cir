.include spice_models/D_1N4148.mod

********************************************************************************
* Circuit
********************************************************************************

* Diode bridge
D1 1 2 D1N4148
D2 0 2 D1N4148
D3 3 0 D1N4148
D4 3 1 D1N4148

* Load
R1 2 3 1k
* VmeasR1 51 3 DC 0
C1 2 3 200u

********************************************************************************
* Voltage source
********************************************************************************

* For the I-V curve, apply a DC V_in sweep
* for the Vout-Vin curve, apply a DC V_in sweep
* V1 1 0 DC 5
* .dc V1 -4 4 0.01      ; Sweep from -2V to +1V in 10mV steps

* SIN(x, y, z) : Voff=x; Vampl=y; Freq=z[Hz]
Vx 1 0 SIN(0 5 10)
.tran 1ms 200ms

********************************************************************************
* Control part
********************************************************************************
.control
run
plot v(1) v(2) v(3) v(2)-v(3)
* plot i(VmeasR1)
.endc

.end
