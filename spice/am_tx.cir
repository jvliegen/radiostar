* SIN(x, y, z) : Voff=x; Vampl=y; Freq=z[Hz]
Vx 1 0 SIN(0 3 6.777k)
.tran 5µs 2ms

********************************************************************************
* Control part
********************************************************************************
.control
run
plot v(1)
.endc

.end
