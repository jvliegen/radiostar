********************************************************************************
* Circuit
********************************************************************************

* Load
R1 1 2 1k
VmeasR1 2 0 DC 0

C1 1 3 10µ
VmeasC1 3 0 DC 0

L1 1 4 10
VmeasL1 4 0 DC 0

********************************************************************************
* Voltage source
********************************************************************************

* For the I-V curve, apply a DC V_in sweep
* for the Vout-Vin curve, apply a DC V_in sweep
* V1 1 0 DC 5
* .dc V1 -4 4 0.01      ; Sweep from -2V to +1V in 10mV steps

* SIN(x, y, z) : Voff=x; Vampl=y; Freq=z[Hz]
Vx 1 0 SIN(0 5 10)
.tran 1ms 200ms

********************************************************************************
* Control part
********************************************************************************
.control
run
* plot v(1), v(2), v(3), v(4)
plot i(VmeasR1), i(VmeasC1), i(VmeasL1)
.endc

.end
